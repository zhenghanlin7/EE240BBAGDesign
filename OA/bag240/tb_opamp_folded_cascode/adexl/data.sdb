ADE simulation setup
Run mode: Single Run, Sweeps and Corners
Tests:
  bag240:tb_opamp_folded_cascode:1: bag240/tb_opamp_folded_cascode/schematic, simulator spectre
Global variables:
  cm_cap = 300f
  L_in = 400n
  L_N = 300n
  L_P = 300n
  N_in = 58
  N_N = 36
  N_NCAS = 6
  N_OS = 60
  N_OSL = 20
  N_P = 6
  N_PCAS = 6
  Rsense = 5k
  VBN = 560m
  VBNCAS = 740m
  VBPCAS = 550m
  W_in = 480n
  W_N = 360n
  W_P = 360n
