ADE simulation setup
Run mode: Single Run, Sweeps and Corners
Tests:
  bag240:tb_opamp_folded_cascode:1: bag240/tb_opamp_folded_cascode/schematic, simulator spectre
Global variables:
  amp = 200m
  vdd = 1.2
  Rsense = 5K
  cm_cap = 300f
  L_in = 400n
  L_N = 300n
  L_P = 300n
  W_in = 480n
  W_N = 360n
  W_P = 360n
  vincm = 375m
  N_in = 58
  N_P = 6
  N_PCAS = 6
  N_NCAS = 6
  N_N = 36
  N_OS = 60
  N_OSL = 20
  VBPCAS = 550m
  VBNCAS = 740m
  VBN = 560m
