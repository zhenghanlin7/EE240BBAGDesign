ADE simulation setup
Run mode: Single Run, Sweeps and Corners
Tests:
  bag240:tb_filter:1: bag240/tb_filter/schematic, simulator spectre
Global variables:
  C1A = 1p
  C1B = 1p
  C2A = 2.26p
  C2B = 5.36p
  L_N = 300n
  L_P = 300n
  L_in = 400n
  N_N = 36
  N_NCAS = 6
  N_OS = 60
  N_OSL = 20
  N_P = 6
  N_PCAS = 6
  N_in = 58
  R1A = 8.66k
  R1B = 5.11k
  R2A = 8.66k
  R2B = 5.11k
  R3A = 6.49k
  R3B = 3.65k
  Rsense = 5K
  VBN = 560m
  VBNCAS = 740m
  VBPCAS = 550m
  W_N = 360n
  W_P = 360n
  W_in = 480n
  amp = 100m
  baseC = 1*0.95
  baseR = 0.5
  cm_cap = 300f
  cmfb = 390m
  mode = -1
  vblk = 1m
  vdd = 1.2
  vincm = 375m
