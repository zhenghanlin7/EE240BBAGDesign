ADE simulation setup
Run mode: Single Run, Sweeps and Corners
Tests:
  bag240:tb_opamp_cmfb_cs:1: bag240/tb_opamp_cmfb_cs/schematic, simulator spectre
